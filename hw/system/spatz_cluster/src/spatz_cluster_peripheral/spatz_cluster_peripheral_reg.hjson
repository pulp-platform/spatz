// Copyright 2020 ETH Zurich and University of Bologna.
// Solderpad Hardware License, Version 0.51, see LICENSE for details.
// SPDX-License-Identifier: SHL-0.51
// Licensed under Solderpad Hardware License, Version 0.51, see LICENSE for details.
{
    param_list: [
	{ name: "NumPerfCounters",
	desc: "Number of performance counters",
	type: "int",
	default: "2"
	},
	{ name: "NumVrfUnits",
	desc: "Number of VRF units (must equal NrCores in the cluster)",
	type: "int",
	default: "1"
	},
	{ name: "NumTcdmBanks",
	desc: "Number of TCDM banks (must equal NrSuperBanks*BanksPerSuperBank in the cluster)",
	type: "int",
	default: "32"
	},
    ],
    name: "spatz_cluster_peripheral",
    clock_primary: "clk_i",
    bus_interfaces: [
	{ protocol: "reg_iface", direction: "device"}
    ]
    regwidth: 64,
    registers: [{
	multireg: {
	    name: "PERF_COUNTER_ENABLE",
	    desc: "Enable particular performance counter and start tracking.",
	    swaccess: "rw",
	    hwaccess: "hro",
	    count: "NumPerfCounters",
	    cname: "performance_counter_enable",
	    fields: [{
		bits: "0:0",
		resval: "0",
		name: "CYCLE",
		desc: '''
		    Cycle counter. Counts up as long as the cluster is powered.
		    '''
	    },
	    {
		bits: "1:1",
		resval: "0",
		name: "TCDM_ACCESSED"
		desc: '''
			Increased whenever the TCDM is accessed. Each individual access is tracked,
			so if `n` cores access the TCDM, `n` will be added. Accesses are tracked at the TCDM,
			so it doesn't matter whether the cores or the for example the SSR hardware accesses
			the TCDM. _This is a cluster-global signal._
			'''
	    },
	    {
		bits: "2:2",
		resval: "0",
		name: "TCDM_CONGESTED"
		desc: '''
			Incremented whenever an access twoards the TCDM is made but the arbitration
			logic didn't grant the access (due to congestion). Is strictly less than TCDM_ACCESSED.
			_This is a cluster-global signal._
			'''
	    },
	    {
		bits: "3:3",
		resval: "0",
		name: "ISSUE_FPU"
		desc: '''
			Core operations performed in the FPU. _This is a hart-local signal._
			'''
	    },
	    {
		bits: "4:4",
		resval: "0",
		name: "ISSUE_FPU_SEQ"
		desc: '''
			Incremented whenever the FPU Sequencer issues an FPU instruction.
			Might be non available if the hardware doesn't support FREP.
			_This is a hart-local signal._
			'''
	    },
	    {
		bits: "5:5",
		resval: "0",
		name: "ISSUE_CORE_TO_FPU"
		desc: '''Incremented whenever the core issues an FPU instruction.
			_This is a hart-local signal._'''
	    },
	    {
		bits: "6:6",
		resval: "0",
		name: "RETIRED_INSTR"
		desc: '''
			Instructions retired by the core. _This is a hart-local signal._
			'''
	    },
	    {
		bits: "7:7",
		resval: "0",
		name: "RETIRED_LOAD"
		desc: '''
			Load instructions retired by the core. _This is a hart-local signal._
			'''
	    },
	    {
		bits: "8:8",
		resval: "0",
		name: "RETIRED_I"
		desc: '''
			Base instructions retired by the core. _This is a hart-local signal._
			'''
	    },
	    {
		bits: "9:9",
		resval: "0",
		name: "RETIRED_ACC"
		desc: '''
			Offloaded instructions retired by the core. _This is a hart-local signal._
			'''
	    },
	    {
		bits: "10:10",
		resval: "0",
		name: "DMA_AW_STALL"
		desc: '''
			Incremented whenever aw_valid = 1 but aw_ready = 0.
			_This is a DMA-local signal_
			'''
	    },
	    {
		bits: "11:11",
		resval: "0",
		name: "DMA_AR_STALL"
		desc: '''
			Incremented whenever ar_valid = 1 but ar_ready = 0.
			_This is a DMA-local signal_
			'''
	    },
	    {
		bits: "12:12",
		resval: "0",
		name: "DMA_R_STALL"
		desc: '''
			Incremented whenever r_ready = 1 but r_valid = 0.
			_This is a DMA-local signal_
			'''
	    },
	    {
		bits: "13:13",
		resval: "0",
		name: "DMA_W_STALL"
		desc: '''
			Incremented whenever w_valid = 1 but w_ready = 0.
			_This is a DMA-local signal_
			'''
	    },
	    {
		bits: "14:14",
		resval: "0",
		name: "DMA_BUF_W_STALL"
		desc: '''
			Incremented whenever w_ready = 1 but w_valid = 0.
			_This is a DMA-local signal_
			'''
	    },
	    {
		bits: "15:15",
		resval: "0",
		name: "DMA_BUF_R_STALL"
		desc: '''
			Incremented whenever r_valid = 1 but r_ready = 0.
			_This is a DMA-local signal_
			'''
	    },
	    {
		bits: "16:16",
		resval: "0",
		name: "DMA_AW_DONE"
		desc: '''
			Incremented whenever AW handshake occurs.
			_This is a DMA-local signal_
			'''
	    },
	    {
		bits: "17:17",
		resval: "0",
		name: "DMA_AW_BW"
		desc: '''
			Whenever AW handshake occurs, the counter is incremented
			by the number of bytes transfered for this transaction
			_This is a DMA-local signal_
			'''
	    },
	    {
		bits: "18:18",
		resval: "0",
		name: "DMA_AR_DONE"
		desc: '''
			Incremented whenever AR handshake occurs.
			_This is a DMA-local signal_
			'''
	    },
	    {
		bits: "19:19",
		resval: "0",
		name: "DMA_AR_BW"
		desc: '''
			Whenever AR handshake occurs, the counter is incremented
			by the number of bytes transfered for this transaction
			_This is a DMA-local signal_
			'''
	    },
	    {
		bits: "20:20",
		resval: "0",
		name: "DMA_R_DONE"
		desc: '''
			Incremented whenever R handshake occurs.
			_This is a DMA-local signal_
			'''
	    },
	    {
		bits: "21:21",
		resval: "0",
		name: "DMA_R_BW"
		desc: '''
			Whenever R handshake occurs, the counter is incremented
			by the number of bytes transfered in this cycle
			_This is a DMA-local signal_
			'''
	    },
	    {
		bits: "22:22",
		resval: "0",
		name: "DMA_W_DONE"
		desc: '''
			Incremented whenvever W handshake occurs.
			_This is a DMA-local signal_
			'''
	    },
	    {
		bits: "23:23",
		resval: "0",
		name: "DMA_W_BW"
		desc: '''
			Whenever W handshake occurs, the counter is incremented
			by the number of bytes transfered in this cycle
			_This is a DMA-local signal_
			'''
	    },
	    {
		bits: "24:24",
		resval: "0",
		name: "DMA_B_DONE"
		desc: '''
			Incremented whenever B handshake occurs.
			_This is a DMA-local signal_
			'''
	    },
	    {
		bits: "25:25",
		resval: "0",
		name: "DMA_BUSY"
		desc: '''
			Incremented whenever DMA is busy.
			_This is a DMA-local signal_
			'''
	    },
			{
		bits: "26:26",
		resval: "0",
		name: "ICACHE_MISS"
		desc: '''
			Incremented for instruction cache misses.
			_This is a hart-local signal_
			'''
	    },
			{
		bits: "27:27",
		resval: "0",
		name: "ICACHE_HIT"
		desc: '''
			Incremented for instruction cache hits.
			_This is a hart-local signal_
			'''
	    },
			{
		bits: "28:28",
		resval: "0",
		name: "ICACHE_PREFETCH"
		desc: '''
			Incremented for instruction cache prefetches.
			_This is a hart-local signal_
			'''
	    },
			{
		bits: "29:29",
		resval: "0",
		name: "ICACHE_DOUBLE_HIT"
		desc: '''
			Incremented for instruction cache double hit.
			_This is a hart-local signal_
			'''
	    },
			{
		bits: "30:30",
		resval: "0",
		name: "ICACHE_STALL"
		desc: '''
			Incremented for instruction cache stalls.
			_This is a hart-local signal_
			'''
	    },
	    ]
	}
    },
    {
	multireg: {
	    name: "HART_SELECT",
	    desc: '''Select from which hart in the cluster, starting from `0`,
		     the event should be counted. For each performance counter
		     the cores can be selected individually. If a hart greater
		     than the clusters total hart size is selected the selection
		     will wrap and the hart corresponding to `hart_select % total_harts_in_cluster`
		     will be selected.'''
	    swaccess: "rw",
	    hwaccess: "hro",
	    count: "NumPerfCounters",
	    cname: "hart_select",
	    compact: "false",
	    fields: [{
		bits: "9:0",
		name: "HART_SELECT",
		desc: "Select source of per-hart performance counter"
	    }]
	}
    }
    {
	multireg: {
	    name: "PERF_COUNTER",
	    desc: '''Performance counter. Set corresponding PERF_COUNTER_ENABLE bits depending on what
	    performance metric you would like to track.'''
	    swaccess: "rw",
	    hwaccess: "hrw",
	    count: "NumPerfCounters",
	    cname: "performance_counter",
	    hwext: "true",
	    hwqe: "true",
	    fields: [{
		bits: "47:0",
		name: "PERF_COUNTER",
		desc: "Performance counter"
	    }]
	}
    },
    {
	name: "CL_CLINT_SET",
	desc: '''
	Set bits in the cluster-local CLINT. Writing a 1 at location i sets the cluster-local interrupt
	of hart i, where i is relative to the first hart in the cluster, ignoring the cluster base hart ID.
	'''
	hwext: "true",
	hwqe: "true",
	swaccess: "wo",
	hwaccess: "hro",
	  fields: [{
	      bits: "31:0",
	      name: "CL_CLINT_SET",
	      desc: "Set cluster-local interrupt of hart i"
	  }]
    },
    {
	name: "CL_CLINT_CLEAR",
	desc: '''
	Clear bits in the cluster-local CLINT. Writing a 1 at location i clears the cluster-local interrupt
	of hart i, where i is relative to the first hart in the cluster, ignoring the cluster base hart ID.
	'''
	hwext: "true",
	hwqe: "true",
	swaccess: "wo",
	hwaccess: "hro",
	  fields: [{
	      bits: "31:0",
	      name: "CL_CLINT_CLEAR",
	      desc: "Clear cluster-local interrupt of hart i"
	  }]
    },
    {
	name: "HW_BARRIER",
	desc: '''Hardware barrier register. Loads to this register will block until all cores have
	performed the load. At this stage we know that they reached the same point in the control flow,
	i.e., the cores are synchronized.'''
	swaccess: "ro",
	hwaccess: "hrw",
	hwext: "true",
	fields: [{
	    bits: "31:0",
	    name: "HW_BARRIER",
	    desc: "Hardware barrier register."
	}]
    },
    {
	name: "ICACHE_PREFETCH_ENABLE",
	desc: '''Controls prefetching of the instruction cache.'''
	swaccess: "wo",
	hwaccess: "hro",
	resval: "1",
	fields: [{
	    bits: "0:0",
	    name: "ICACHE_PREFETCH_ENABLE",
	    desc: "Hardware barrier register."
	}]
    },
    {
	name: "SPATZ_STATUS",
	desc: '''Sets the status of the Spatz cluster.'''
	swaccess: "wo",
	hwaccess: "hro",
	fields: [{
	    bits: "0:0",
	    resval: "0",
	    name: "SPATZ_CLUSTER_PROBE",
	    desc: "Indicates the cluster is computing a kernel."
	}]
    },
    {
	name: "CLUSTER_BOOT_CONTROL",
	desc: '''Controls the cluster boot process.'''
	swaccess: "rw",
	hwaccess: "hro",
	resval: "0",
	fields: [{
	    bits: "31:0",
	    name: "ENTRY_POINT",
	    desc: "Post-bootstrapping entry point."
	}]
    },
    {
	name: "CLUSTER_EOC_EXIT",
	desc: '''End of computation and exit status register'''
	swaccess: "rw",
	hwaccess: "hro",
	resval: "0",
	fields: [{
	    bits: "31:0",
	    name: "EOC_EXIT",
	    desc: "Indicates the end of computation and exit status."
	}]
     },
     {
	name: "ERR_MONITOR_CLEAR",
	desc: '''Write 1 to clear all error monitor counters; write 0 to resume counting.'''
	swaccess: "rw",
	hwaccess: "hro",
	resval: "0",
	fields: [{
	    bits: "0:0",
	    name: "CLEAR",
	    desc: "Level-sensitive clear for all ECC error counters in the fault monitor."
	}]
     },
     {
	multireg: {
	    name: "VRF_CORRECTABLE_COUNT",
	    desc: "Per-VRF-unit correctable (single-bit) ECC error counter.",
	    swaccess: "ro",
	    hwaccess: "hrw",
	    hwext: "true",
	    count: "NumVrfUnits",
	    compact: "false",
	    cname: "vrf_correctable_count",
	    fields: [{
		bits: "31:0",
		name: "COUNT",
		desc: "Saturating count of correctable ECC errors for this VRF unit."
	    }]
	}
     },
     {
	multireg: {
	    name: "VRF_UNCORRECTABLE_COUNT",
	    desc: "Per-VRF-unit uncorrectable (multi-bit) ECC error counter.",
	    swaccess: "ro",
	    hwaccess: "hrw",
	    hwext: "true",
	    count: "NumVrfUnits",
	    compact: "false",
	    cname: "vrf_uncorrectable_count",
	    fields: [{
		bits: "31:0",
		name: "COUNT",
		desc: "Saturating count of uncorrectable ECC errors for this VRF unit."
	    }]
	}
     },
     {
	multireg: {
	    name: "TCDM_RD_CORRECTABLE_COUNT",
	    desc: "Per-TCDM-bank correctable read ECC error counter.",
	    swaccess: "ro",
	    hwaccess: "hrw",
	    hwext: "true",
	    count: "NumTcdmBanks",
	    compact: "false",
	    cname: "tcdm_rd_correctable_count",
	    fields: [{
		bits: "31:0",
		name: "COUNT",
		desc: "Saturating count of correctable read ECC errors for this TCDM bank."
	    }]
	}
     },
     {
	multireg: {
	    name: "TCDM_RD_UNCORRECTABLE_COUNT",
	    desc: "Per-TCDM-bank uncorrectable read ECC error counter.",
	    swaccess: "ro",
	    hwaccess: "hrw",
	    hwext: "true",
	    count: "NumTcdmBanks",
	    compact: "false",
	    cname: "tcdm_rd_uncorrectable_count",
	    fields: [{
		bits: "31:0",
		name: "COUNT",
		desc: "Saturating count of uncorrectable read ECC errors for this TCDM bank."
	    }]
	}
     },
     {
	multireg: {
	    name: "TCDM_SCRUB_CORRECTABLE_COUNT",
	    desc: "Per-TCDM-bank correctable scrub ECC error counter.",
	    swaccess: "ro",
	    hwaccess: "hrw",
	    hwext: "true",
	    count: "NumTcdmBanks",
	    compact: "false",
	    cname: "tcdm_scrub_correctable_count",
	    fields: [{
		bits: "31:0",
		name: "COUNT",
		desc: "Saturating count of correctable scrub ECC errors for this TCDM bank."
	    }]
	}
     },
     {
	multireg: {
	    name: "TCDM_SCRUB_UNCORRECTABLE_COUNT",
	    desc: "Per-TCDM-bank uncorrectable scrub ECC error counter.",
	    swaccess: "ro",
	    hwaccess: "hrw",
	    hwext: "true",
	    count: "NumTcdmBanks",
	    compact: "false",
	    cname: "tcdm_scrub_uncorrectable_count",
	    fields: [{
		bits: "31:0",
		name: "COUNT",
		desc: "Saturating count of uncorrectable scrub ECC errors for this TCDM bank."
	    }]
	}
     },
     {
	multireg: {
	    name: "FPU_DUP_FAULT_COUNT",
	    desc: "Per-core FPU duplication (DMR) mismatch counter. Always uncorrectable-class (DMR alone cannot tell which of the two fpnew_top copies is right).",
	    swaccess: "ro",
	    hwaccess: "hrw",
	    hwext: "true",
	    count: "NumVrfUnits",
	    compact: "false",
	    cname: "fpu_dup_fault_count",
	    fields: [{
		bits: "31:0",
		name: "COUNT",
		desc: "Saturating count of FPU duplication mismatches for this core."
	    }]
	}
     },
     {
	multireg: {
	    name: "HANDSHAKE_TMR_COUNT",
	    desc: "Per-core TMR (triplicate + majority vote) mismatch counter, covering every triplicated persistent flag and FSM state register in that core's Spatz vector unit. Self-corrected by the voter the same cycle -- diagnostic/counter-only, never escalated to the uncorrectable-fault recovery interrupt.",
	    swaccess: "ro",
	    hwaccess: "hrw",
	    hwext: "true",
	    count: "NumVrfUnits",
	    compact: "false",
	    cname: "handshake_tmr_count",
	    fields: [{
		bits: "31:0",
		name: "COUNT",
		desc: "Saturating count of TMR-voter mismatches for this core's Spatz vector unit."
	    }]
	}
     },
     {
	multireg: {
	    name: "CORE_TMR_COUNT",
	    desc: "Per-core lockstep (triplicated) Snitch core mismatch counter. Self-corrected by the voter the same cycle -- diagnostic/counter-only, never escalated to the uncorrectable-fault recovery interrupt.",
	    swaccess: "ro",
	    hwaccess: "hrw",
	    hwext: "true",
	    count: "NumVrfUnits",
	    compact: "false",
	    cname: "core_tmr_count",
	    fields: [{
		bits: "31:0",
		name: "COUNT",
		desc: "Saturating count of lockstep Snitch core replica mismatches for this core."
	    }]
	}
     },
     {
	multireg: {
	    name: "ICACHE_L0_CORRECTABLE_COUNT",
	    desc: "Per-core private L0 icache data-array correctable (single-bit) ECC error counter. Tag arrays are unprotected this round.",
	    swaccess: "ro",
	    hwaccess: "hrw",
	    hwext: "true",
	    count: "NumVrfUnits",
	    compact: "false",
	    cname: "icache_l0_correctable_count",
	    fields: [{
		bits: "31:0",
		name: "COUNT",
		desc: "Saturating count of correctable L0 icache data-array ECC errors for this core."
	    }]
	}
     },
     {
	multireg: {
	    name: "ICACHE_L0_UNCORRECTABLE_COUNT",
	    desc: "Per-core private L0 icache data-array uncorrectable (multi-bit) ECC error counter.",
	    swaccess: "ro",
	    hwaccess: "hrw",
	    hwext: "true",
	    count: "NumVrfUnits",
	    compact: "false",
	    cname: "icache_l0_uncorrectable_count",
	    fields: [{
		bits: "31:0",
		name: "COUNT",
		desc: "Saturating count of uncorrectable L0 icache data-array ECC errors for this core."
	    }]
	}
     },
     {
	name: "ICACHE_L1_CORRECTABLE_COUNT",
	desc: '''Shared L1 icache data-array correctable (single-bit) ECC error counter. L1 is a
	single cache shared by the whole cluster, not attributable to one core -- unlike the
	per-core VRF/L0 counters above, this is one scalar counter. Tag arrays are unprotected
	this round.
	'''
	swaccess: "ro",
	hwaccess: "hrw",
	hwext: "true",
	fields: [{
	    bits: "31:0",
	    name: "COUNT",
	    desc: "Saturating count of correctable L1 icache data-array ECC errors."
	}]
     },
     {
	name: "ICACHE_L1_UNCORRECTABLE_COUNT",
	desc: "Shared L1 icache data-array uncorrectable (multi-bit) ECC error counter."
	swaccess: "ro",
	hwaccess: "hrw",
	hwext: "true",
	fields: [{
	    bits: "31:0",
	    name: "COUNT",
	    desc: "Saturating count of uncorrectable L1 icache data-array ECC errors."
	}]
     },
     {
	name: "UNCORRECTABLE_IRQ_ENABLE",
	desc: '''Per-hart enable for the uncorrectable-fault recovery interrupt. Bit i gates whether a
	Class-A uncorrectable fault attributed to hart i (VRF ECC uncorrectable, TCDM ECC
	uncorrectable read/scrub (cluster-global, broadcast to every hart), L0 icache
	data-array uncorrectable, L1 icache data-array uncorrectable (cluster-global,
	broadcast to every hart), or FPU duplication mismatch) is allowed to set that hart's
	bit in UNCORRECTABLE_IRQ_STATUS.
	'''
	swaccess: "rw",
	hwaccess: "hro",
	resval: "4294967295",
	fields: [{
	    bits: "31:0",
	    name: "ENABLE",
	    desc: "Per-hart uncorrectable-fault recovery-interrupt enable."
	}]
     },
     {
	name: "UNCORRECTABLE_IRQ_STATUS",
	desc: '''
	Sticky per-hart status: bit i is set when hart i has suffered (or, for cluster-global
	faults such as TCDM ECC, when the cluster as a whole has suffered) a Class-A
	uncorrectable fault that triggered the recovery interrupt. Cleared by writing 1 to the
	matching bit in UNCORRECTABLE_IRQ_CLEAR. Software should read this register from the
	trap handler to distinguish a fault-induced mcip from a regular inter-core IPI, and to
	identify which hart's kernel needs to be restarted.
	'''
	swaccess: "ro",
	hwaccess: "hrw",
	hwext: "true",
	fields: [{
	    bits: "31:0",
	    name: "STATUS",
	    desc: "Per-hart uncorrectable-fault recovery-interrupt status."
	}]
     },
     {
	name: "UNCORRECTABLE_IRQ_CLEAR",
	desc: '''
	Clear bits in UNCORRECTABLE_IRQ_STATUS. Writing a 1 at bit i clears the sticky
	uncorrectable-fault status of hart i, where i is relative to the first hart in the
	cluster, ignoring the cluster base hart ID.
	'''
	hwext: "true",
	hwqe: "true",
	swaccess: "wo",
	hwaccess: "hro",
	fields: [{
	    bits: "31:0",
	    name: "UNCORRECTABLE_IRQ_CLEAR",
	    desc: "Clear sticky uncorrectable-fault status of hart i"
	}]
     }
  ]
}
